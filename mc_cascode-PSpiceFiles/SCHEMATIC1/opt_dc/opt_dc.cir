** Profile: "SCHEMATIC1-opt_dc"  [ c:\cadence\pspice sim\mc_cascode-PSpiceFiles\SCHEMATIC1\opt_dc.sim ]

** Creating circuit file "opt_dc.cir"
** WARNING: THIS AUTOMATICALLY GENERATED FILE MAY BE OVERWRITTEN BY SUBSEQUENT SIMULATIONS

*Libraries:
* Profile Libraries :
* Local Libraries :
.LIB "../../../mc_cascode-pspicefiles/mc_cascode.lib"
* From [PSPICE NETLIST] section of C:\Users\ROG\AppData\Roaming\SPB_Data\cdssetup\OrCAD_PSpice\24.1.0\PSpice.ini file:
.lib "nom.lib"

*Analysis directives:
.DC V_V3 LIST 0
.OPTIONS ADVCONV
.PROBE64 V(alias(*)) I(alias(*)) W(alias(*)) D(alias(*)) NOISE(alias(*))
.INC "..\SCHEMATIC1.net"

.END
