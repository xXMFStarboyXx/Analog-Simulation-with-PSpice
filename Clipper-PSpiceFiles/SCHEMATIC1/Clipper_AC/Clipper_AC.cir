** Profile: "SCHEMATIC1-Clipper_AC"  [ C:\Cadence\Pspice sim\Clipper-PSpiceFiles\SCHEMATIC1\Clipper_AC.sim ]

** Creating circuit file "Clipper_AC.cir"
** WARNING: THIS AUTOMATICALLY GENERATED FILE MAY BE OVERWRITTEN BY SUBSEQUENT SIMULATIONS

*Libraries:
* Profile Libraries :
* Local Libraries :
* From [PSPICE NETLIST] section of C:\Users\ROG\AppData\Roaming\SPB_Data\cdssetup\OrCAD_PSpice\24.1.0\PSpice.ini file:
.lib "nom.lib"

*Analysis directives:
.AC DEC 11 10 100Meg
.OPTIONS ADVCONV
.PROBE64 V(*) I(*) W(*) D(*) NOISE(*)
.INC "..\SCHEMATIC1.net"

.END
